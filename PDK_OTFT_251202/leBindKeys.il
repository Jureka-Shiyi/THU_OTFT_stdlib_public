;;-----------------------------------------------------------------------------
;; Bindkeys for 'Layout'
;; Inherited by:
;;             * PcellIDE Layout
;;             * VLS-GXL
;;             * Virtuoso XL
;;             * adegxl-maskLayout
;;             * adexl-maskLayout
;;             * assembler-maskLayout
;;             * explorer-maskLayout
;;-----------------------------------------------------------------------------
hiSetBindKeys("Layout" list(
    list("<DrawThru1>" "geSingleSelectBox()")
    list("<DrawThru2>" "" "_cmdOptionDrawThru2()")
    list("<DrawThru3>" "hiZoomIn()" "hiZoomIn()")
    list("<Key>\"" "deToggleAssistantVisibility(\"World View\")")
    list("<Key>#" "hiToggleAnchorMagnifier()")
    list("<Key>+" "leIncrementStopLevelByOne(hiGetCurrentWindow())")
    list("<Key>," "_leChangeEditMode(\"a\")")
    list("<Key>-" "leDecrementStopLevelByOne(hiGetCurrentWindow())")
    list("<Key>." "_leChangeEditMode(\"r\")")
    list("<Key>`" " leSetEntryLayer(list(\"ITO\" \"pin\"))   leSetEntryLayer(list(\"ITO\" \"drawing\"))            hiRedraw()")
    list("<Key>0"  "leSetEntryLayer(list(\"MC\" \"pin\"))          leSetEntryLayer(list(\"MC\" \"drawing\"))            hiRedraw()")
    list("<Key>1"	"leSetEntryLayer(list(\"M1\" \"pin\")) leSetEntryLayer(list(\"M1\" \"drawing\")) hiRedraw()"	"drdEnablePixelThreshold(!drdIsPixelThresholdEnabled())")
    list("<Key>2"	"leSetEntryLayer(list(\"M2\" \"pin\")) leSetEntryLayer(list(\"M2\" \"drawing\")) hiRedraw()")
    list("<Key>3"	"leSetEntryLayer(list(\"M3\" \"pin\")) leSetEntryLayer(list(\"M3\" \"drawing\")) hiRedraw()")
    list("<Key>4"	"leSetEntryLayer(list(\"M4\" \"pin\")) leSetEntryLayer(list(\"M4\" \"drawing\")) hiRedraw()")
    list("<Key>5"	"leSetEntryLayer(list(\"M5\" \"pin\")) leSetEntryLayer(list(\"M5\" \"drawing\")) hiRedraw()")
    list("<Key>6"	"leSetEntryLayer(list(\"M6\" \"pin\")) leSetEntryLayer(list(\"M6\" \"drawing\")) hiRedraw()")
    list("<Key>7"	"leSetEntryLayer(list(\"M7\" \"pin\")) leSetEntryLayer(list(\"M7\" \"drawing\")) hiRedraw()")
    list("<Key>8"	"leSetEntryLayer(list(\"M8\" \"pin\")) leSetEntryLayer(list(\"M8\" \"drawing\")) hiRedraw()")
    list("<Key>9"	"leSetEntryLayer(list(\"M9\" \"pin\")) leSetEntryLayer(list(\"M9\" \"drawing\")) hiRedraw()")
    list("<Key>A"	"leHiQuickAlign()")
    list("<Key>B"	"leReturn()")
    list("<Key>BackSpace"	"deletePoint()"	"deletePoint()")
    list("<Key>C"	"leHiCopy()")
    list("<Key>D"	"geSubSelectPoint()")
    list("<Key>Delete"	"leHiDelete()"	"leHiDelete()")
    list("<Key>Down"	"geScroll(nil \"s\"    nil)")
    list("<Key>E"	"leHiEditDisplayOptions()")
    list("<Key>Escape"	""	"cancelEnterFun()")
    list("<Key>F"	"hiZoomAbsoluteScale(hiGetCurrentWindow() 0.9)")
    list("<Key>F1"	"leHiSearch()")
    list("<Key>F11"	"deToggleAssistants()")
    list("<Key>F2"	"geSave()")
    list("<Key>F3"	"geSaveAs()"	"hiToggleEnterForm()")
    list("<Key>F4"	"geTogglePartialSelect()")
    list("<Key>F5"	"deFileOpen()")
    list("<Key>F6"	"leToggleMaintainConnections()")
    list("<Key>F7"	"leHiEditDRDRuleOptions()")
    list("<Key>F9"	"geToggleFilterSize()")
    list("<Key>G"	"leToggleGravity()")
    list("<Key>H"	"leHiRepeatCopy()")
    list("<Key>I"	"leHiCreateInst()")
    list("<Key>J"	"geSelObjectsPartiallySelected()")
    list("<Key>K"	"leHiCreateRuler()")
    list("<Key>KP_0"	"cutLineEnd()")
    list("<Key>KP_1"	"CopyPinToCurrentWindow()")
    list("<Key>KP_Add"	"leHiSetRefPoint()")
    list("<Key>KP_Divide"	"drdAddTarget()"	"drdAddTarget()")
    list("<Key>KP_Enter"	"mouseAddPt()")
    list("<Key>KP_Equal"	"legRpDelta = 0.5")
    list("<Key>KP_Multiply"	"drdRemoveTarget()"	"drdRemoveTarget()")
    list("<Key>KP_Subtract"	"leSetRefPointInactive(geGetEditCellView())")
    list("<Key>L"	"leHiCreateLabel(hiGetCurrentWindow() leGetEnv(\"labelMode\"))")
    list("<Key>Left"	"geScroll(nil \"w\"    nil)")
    list("<Key>M"	"leHiMove()")
    list("<Key>N"	"leHiMarkNet()")
    list("<Key>O"	"leHiCreateVia()")
    list("<Key>P"	"leHiCreateMPP()")
    list("<Key>Q"	"leHiEditProp()")
    list("<Key>R"	"leHiCreateRect()")
    list("<Key>R11"	"geScroll(nil \"\"    nil)")
    list("<Key>R13"	"geScroll(nil \"sw\"    nil)")
    list("<Key>R15"	"geScroll(nil \"se\"    nil)")
    list("<Key>R4"	"legRpDelta = 0.5")
    list("<Key>R5"	"legRpDelta = 1.0")
    list("<Key>R6"	"legRpDelta = 2.0")
    list("<Key>R7"	"geScroll(nil \"nw\"    nil)")
    list("<Key>R9"	"geScroll(nil \"ne\"    nil)")
    list("<Key>Right"	"geScroll(nil \"e\"    nil)")
    list("<Key>S"	"leHiStretch()")
    list("<Key>T"	"leHiLayerTap()")
    list("<Key>Tab"	"hiPan()"	"leSetFocusToEditableFieldsInStatusToolbar(hiGetCurrentWindow())")
    list("<Key>U"	"hiUndo()")
    list("<Key>Up"	"geScroll(nil \"n\"    nil)")
    list("<Key>V"	"leHiAttach()")
    list("<Key>W"	"hiPrevWinView(hiGetCurrentWindow())")
    list("<Key>X"	"leHiEditInPlace()")
    list("<Key>Y"	"leHiYank()")
    list("<Key>Z"	"hiZoomIn()")
    list("<Key>]"	"leConvertIBToDSIB()")
    list("<Key>^"	"leHiTree")
;;    list("<Key>`"	""	"drdToggleSmartSnapMode()")
    list("<Key>space"	"leHiAddWireVia(hiGetCurrentWindow())"	"leSpaceBarFunc(hiGetCurrentWindow() t)")
    list("Ctrl Shift<Btn1Down>"	"hiZoomInMagnifier(hiGetCurrentWindow())")
    list("Ctrl Shift<Btn2Down>"	"hiZoomOutMagnifier(hiGetCurrentWindow())")
    list("Ctrl Shift<Btn4Down>"	"_leWireCmdMagnifierOrIncreaseWidth()"	"weScaleMagnifierOrIncreaseWidth()")
    list("Ctrl Shift<Btn5Down>"	"_leWireCmdMagnifierOrDecreaseWidth()"	"weScaleMagnifierOrDecreaseWidth()")
    list("Ctrl Shift<Key>1"	"leSetEntryLayer(\"VIA12\") hiRedraw()")
    list("Ctrl Shift<Key>2"	"leSetEntryLayer(\"VIA23\") hiRedraw()")
    list("Ctrl Shift<Key>3"	"leSetEntryLayer(\"VIA34\") hiRedraw()")
    list("Ctrl Shift<Key>4"	"leSetEntryLayer(\"VIA45\") hiRedraw()")
    list("Ctrl Shift<Key>5"	"leSetEntryLayer(list(\"T4V2\" \"drawing\")) hiRedraw()")
    list("Ctrl Shift<Key>6"	"leSetEntryLayer(list(\"T4V2\" \"drawing\")) hiRedraw()")
    list("Ctrl Shift<Key>7"	"leSetEntryLayer(list(\"RV\" \"drawing\")) leSetEntryLayer(list(\"CB\" \"drawing\")) leSetEntryLayer(list(\"CB2\" \"drawing\")) hiRedraw()")
    list("Ctrl Shift<Key>A"	"leSetAllLayerVisible(t) hiRedraw()")
    list("Ctrl Shift<Key>D"	"leHiP2P()")
    list("Ctrl Shift<Key>Down"	"hiScaleMagnifier(0.80)")
    list("Ctrl Shift<Key>E"	"leHiAddWireVia(hiGetCurrentWindow() \"targetLayers\")")
    list("Ctrl Shift<Key>F"	"leFinishEntireNet()")
    list("Ctrl Shift<Key>G"	"_weGatherBusWires(hiGetCurrentWindow() not(_weIsGatheringBusWires(hiGetCurrentWindow())))")
    list("Ctrl Shift<Key>H"	"drdCompactSelSet('left)")
    list("Ctrl Shift<Key>J"	"drdCompactSelSet('right)")
    list("Ctrl Shift<Key>K"	"leHiClearRulerInHier()")
    list("Ctrl Shift<Key>N"	"drdCompactSelSet('bottom)")
    list("Ctrl Shift<Key>O"	"leSetEntryLayer(\"CONT\") hiRedraw()")
    list("Ctrl Shift<Key>Q"	"leHiAddWireVia(hiGetCurrentWindow() \"up\")")
    list("Ctrl Shift<Key>S"	"leHiGuidedRouting()")
    list("Ctrl Shift<Key>T"	"drdCompactSelSet('target)")
    list("Ctrl Shift<Key>U"	"drdCompactSelSet('top)")
    list("Ctrl Shift<Key>Up"	"hiScaleMagnifier(1.25)")
    list("Ctrl Shift<Key>V"	"leFinishWire()"	"leFinishWire()")
    list("Ctrl Shift<Key>W"	"leHiCreateWire()")
    list("Ctrl Shift<Key>X"	"leHiCreateBus()")
    list("Ctrl Shift<Key>Z"	"leWECycleControlWire()")
    list("Ctrl Shift<Key>space"	"(leWENoSnap)"	"leSpaceBarFunc(hiGetCurrentWindow() \"ctrlShift\")")
    list("Ctrl<Btn1Down>"	"mouseSubSelectPt()"	"mouseSubSelectPt()")
    list("Ctrl<Btn2Down>"	""	"cmdCtrlOption()")
    list("Ctrl<Btn4Down>"	"geScroll(nil \"n\" nil)"	"_leWireCmdScrollOrCycleUpWireViaAlignment()")
    list("Ctrl<Btn5Down>"	"geScroll(nil \"s\" nil)"	"_leWireCmdScrollOrCycleDownWireViaAlignment()")
    list("Ctrl<DrawThru1>"	"geSubSelectBox()"	"geSubSelectBox()")
    list("Ctrl<Key>`"	"leSetEntryLayer(list(\"AP\" \"drawing\")) leSetEntryLayer(list(\"ITO\" \"drawing\")) leSetAllLayerVisible(nil) leSetEntryLayer(list(\"text\" \"drawing\")) leSetEntryLayer(list(\"AP\" \"pin\")) leSetEntryLayer(list(\"AP\" \"odummy\")) leSetEntryLayer(list(\"AP\" \"dummy\")) leSetEntryLayer(list(\"AP\" \"drawing\")) leSetEntryLayer(list(\"ITO\" \"pin\")) leSetEntryLayer(list(\"ITO\" \"odummy\")) leSetEntryLayer(list(\"ITO\" \"dummy\")) leSetEntryLayer(list(\"ITO\" \"drawing\")) hiRedraw()")
    list("Ctrl<Key>0"	"leSetEntryLayer(list(\"M10\" \"drawing\")) leSetEntryLayer(list(\"MC\" \"drawing\")) leSetAllLayerVisible(nil) leSetEntryLayer(list(\"text\" \"drawing\")) leSetEntryLayer(list(\"M10\" \"pin\")) leSetEntryLayer(list(\"M10\" \"odummy\")) leSetEntryLayer(list(\"M10\" \"dummy\")) leSetEntryLayer(list(\"M10\" \"drawing\")) leSetEntryLayer(list(\"MC\" \"pin\")) leSetEntryLayer(list(\"MC\" \"odummy\")) leSetEntryLayer(list(\"MC\" \"dummy\")) leSetEntryLayer(list(\"MC\" \"drawing\")) hiRedraw()")
    list("Ctrl<Key>1"	"leSetEntryLayer(\"M1\") leSetAllLayerVisible(nil) leSetEntryLayer(\"TEXT\") leSetEntryLayer(list(\"M1\" \"pin\")) leSetEntryLayer(\"M1\") hiRedraw()")
    list("Ctrl<Key>2"	"leSetEntryLayer(\"M2\") leSetAllLayerVisible(nil) leSetEntryLayer(\"TEXT\") leSetEntryLayer(list(\"M2\" \"pin\")) leSetEntryLayer(\"M2\") hiRedraw()")
    list("Ctrl<Key>3"	"leSetEntryLayer(\"M3\") leSetAllLayerVisible(nil) leSetEntryLayer(\"TEXT\") leSetEntryLayer(list(\"M3\" \"pin\")) leSetEntryLayer(\"M3\") hiRedraw()")
    list("Ctrl<Key>4"	"leSetEntryLayer(\"M4\") leSetAllLayerVisible(nil) leSetEntryLayer(\"TEXT\") leSetEntryLayer(list(\"M4\" \"pin\")) leSetEntryLayer(\"M4\") hiRedraw()")
    list("Ctrl<Key>5"	"leSetEntryLayer(list(\"M5\" \"drawing\")) leSetAllLayerVisible(nil) leSetEntryLayer(list(\"text\" \"drawing\")) leSetEntryLayer(list(\"M5\" \"pin\")) leSetEntryLayer(list(\"M5\" \"drawing\")) hiRedraw()")
    list("Ctrl<Key>6"	"leSetEntryLayer(list(\"M6\" \"drawing\")) leSetAllLayerVisible(nil) leSetEntryLayer(list(\"text\" \"drawing\")) leSetEntryLayer(list(\"M6\" \"pin\")) leSetEntryLayer(list(\"M6\" \"drawing\")) hiRedraw()")
    list("Ctrl<Key>7"	"leSetEntryLayer(list(\"M7\" \"drawing\")) leSetAllLayerVisible(nil) leSetEntryLayer(list(\"text\" \"drawing\")) leSetEntryLayer(list(\"M7\" \"pin\")) leSetEntryLayer(list(\"M7\" \"odummy\")) leSetEntryLayer(list(\"M7\" \"dummy\")) leSetEntryLayer(list(\"M7\" \"drawing\")) hiRedraw()")
    list("Ctrl<Key>8"	"leSetEntryLayer(list(\"M8\" \"drawing\")) leSetAllLayerVisible(nil) leSetEntryLayer(list(\"text\" \"drawing\")) leSetEntryLayer(list(\"M8\" \"pin\")) leSetEntryLayer(list(\"M8\" \"odummy\")) leSetEntryLayer(list(\"M8\" \"dummy\")) leSetEntryLayer(list(\"M8\" \"drawing\")) hiRedraw()")
    list("Ctrl<Key>9"	"leSetEntryLayer(list(\"M9\" \"drawing\")) leSetAllLayerVisible(nil) leSetEntryLayer(list(\"text\" \"drawing\")) leSetEntryLayer(list(\"M9\" \"pin\")) leSetEntryLayer(list(\"M9\" \"odummy\")) leSetEntryLayer(list(\"M9\" \"dummy\")) leSetEntryLayer(list(\"M9\" \"drawing\")) hiRedraw()")
    list("Ctrl<Key>A"	"geSelectAllFig()")
    list("Ctrl<Key>B"	"leBalloonToggleOnOff()")
    list("Ctrl<Key>C"	"mgc_rve_end_enter_function_binding(\"Layout\")")
    list("Ctrl<Key>D"	"geDeselectAllFig()")
    list("Ctrl<Key>Down"	"geScroll(nil \"s\"    t)")
    list("Ctrl<Key>E"	"leToggleDrdMode()")
    list("Ctrl<Key>F"	"hiGetCurrentWindow()->stopLevel = 0")
    list("Ctrl<Key>F11"	"deToggleToolbars()")
    list("Ctrl<Key>G"	"geZoomToGrid(hiGetCurrentWindow())")
    list("Ctrl<Key>H"	"geDSAFreeze(hiGetCurrentWindow()  hiGetPoint(hiGetCurrentWindow()))")
    list("Ctrl<Key>I"	"leBalloonCycleThru()")
    list("Ctrl<Key>J"	"leHiFlip()")
    list("Ctrl<Key>K"	"leToggleKeepFirstName()")
    list("Ctrl<Key>L"	""	"weCWHoldWidth()")
    list("Ctrl<Key>Left"	"geScroll(nil \"w\"    t)")
    list("Ctrl<Key>M"	"leHiMakeCell()")
    list("Ctrl<Key>N"	"leSetFormSnapMode(\"L90XFirst\")")
    list("Ctrl<Key>O"	"geSelectViaPile()")
    list("Ctrl<Key>P"	"leHiCreatePin()")
    list("Ctrl<Key>R"	"hiRedraw()")
    list("Ctrl<Key>R11"	"geScroll(nil \"\"    t)")
    list("Ctrl<Key>R13"	"geScroll(nil \"sw\"    t)")
    list("Ctrl<Key>R15"	"geScroll(nil \"se\"    t)")
    list("Ctrl<Key>R7"	"geScroll(nil \"nw\"    t)")
    list("Ctrl<Key>R9"	"geScroll(nil \"ne\"    t)")
    list("Ctrl<Key>Right"	"geScroll(nil \"e\"    t)")
    list("Ctrl<Key>S"	"leHiSplit()")
    list("Ctrl<Key>T"	"leZoomToSelSet()")
    list("Ctrl<Key>Tab"	"hiLowerWindow(hiGetCurrentWindow())")
    list("Ctrl<Key>Up"	"geScroll(nil \"n\"    t)")
    list("Ctrl<Key>V"	"leHiCreatePath()")
    list("Ctrl<Key>W"	"leCloseWindow()")
    list("Ctrl<Key>X"	"leEIPZoomAbsoluteScale(hiGetCurrentWindow() 0.9)")
    list("Ctrl<Key>Y"	"geCycleSelectNext()")
    list("Ctrl<Key>Z"	"hiZoomRelativeScale(hiGetCurrentWindow() 2.0)")
    list("Ctrl<Key>space"	"(leWECycleSnap)"	"leSpaceBarFunc(hiGetCurrentWindow() \"cancel\")")
    list("None<Btn1Down>"	"mouseSingleSelectPt() _leiLMBPress()"	"mouseAddPt(t)")
    list("None<Btn1Down>(2)"	"leDoubleClick()"	"mouseApplyOrFinishPoint()")
    list("None<Btn2Down>"	"hiRepeat()"	"cmdOption()")
    list("None<Btn3Down>"	"hiRepeat()"	"cmdOption()")
    list("None<Btn3Down>(2)"	"leHiEditProp()"	"hiToggleEnterForm()")
    list("None<Btn4Down>"	"hiZoomInAtMouse()")
    list("None<Btn5Down>"	"hiZoomOutAtMouse()")
    list("Return"	""	"mouseApplyOrFinishPoint()")
    list("Shift<Btn1Down>"	"mouseAddSelectPt()"	"mouseAddSelectPt()")
    list("Shift<Btn2Down>"	""	"cmdShiftOption()")
    list("Shift<Btn4Down>"	"geScroll(nil \"w\" nil)")
    list("Shift<Btn5Down>"	"geScroll(nil \"e\" nil)")
    list("Shift<DrawThru1>"	"geAddSelectBox()"	"geAddSelectBox()")
    list("Shift<DrawThru3>"	"hiZoomOut()"	"hiZoomOut()")
    list("Shift<Key>A"	"geSelectArea()")
    list("Shift<Key>B"	"leReturn()")
    list("Shift<Key>C"	"leHiChop()")
    list("Shift<Key>D"	"geSubSelectBox()")
    list("Shift<Key>Down"	"leMoveCursor(0           -legRpDelta)")
    list("Shift<Key>E"	"leHiEditEditorOptions()")
    list("Shift<Key>F"	"hiGetCurrentWindow()->stopLevel = dbGetMaxHierDepth()")
    list("Shift<Key>F11"	"deToggleToolbars() deToggleAssistants()")
    list("Shift<Key>F4"	"geToggleAreaSelectOption()")
    list("Shift<Key>F5"	"leFullSelectFigOfSelSet()")
    list("Shift<Key>G"	"leHiCreateGuardRing()")
    list("Shift<Key>I"	"leHiGuidedRoutingReverseEnvelope(hiGetCurrentWindow())")
    list("Shift<Key>K"	"leHiClearRuler()")
    list("Shift<Key>Left"	"leMoveCursor(-legRpDelta           0)")
    list("Shift<Key>M"	"leHiMerge()")
    list("Shift<Key>N"	"leHiUnmarkNet()")
    list("Shift<Key>O"	"leHiMoveOrigin()")
    list("Shift<Key>P"	"leHiCreatePath()")
    list("Shift<Key>Q"	"leEditDesignProperties()")
    list("Shift<Key>R"	"leHiReShape()")
    list("Shift<Key>R11"	"leMoveCursorToRefPoint()")
    list("Shift<Key>R13"	"leMoveCursor(-legRpDelta -legRpDelta)")
    list("Shift<Key>R15"	"leMoveCursor( legRpDelta -legRpDelta)")
    list("Shift<Key>R7"	"leMoveCursor(-legRpDelta  legRpDelta)")
    list("Shift<Key>R9"	"leMoveCursor( legRpDelta  legRpDelta)")
    list("Shift<Key>Right"	"leMoveCursor( legRpDelta           0)")
    list("Shift<Key>S"	"leHiSearch()")
    list("Shift<Key>T"	"leHiFlatten()")
    list("Shift<Key>U"	"hiRedo()")
    list("Shift<Key>Up"	"leMoveCursor(          0  legRpDelta)")
    list("Shift<Key>V"	"leSetAllLayerVisible(t) hiRedraw()")
    list("Shift<Key>W"	"hiNextWinView(hiGetCurrentWindow())")
    list("Shift<Key>X"	"leHiDescend()")
    list("Shift<Key>Y"	"leHiPaste()")
    list("Shift<Key>Z"	"hiZoomRelativeScale(hiGetCurrentWindow() 0.5)")
;;    list("Shift<Key>`"	""	"drdToggleSmartSnapModeForDiscreteSpacing()")
    list("Shift<Key>space"	""	"leSpaceBarFunc(hiGetCurrentWindow() t t)")

    ;; Empty bindkeys (typically inserted when a bindkey is redefined or deleted)
    list("<Key>'"	"")
)
) ;; hiSetBindKeys
;;-----------------------------------------------------------------------------
